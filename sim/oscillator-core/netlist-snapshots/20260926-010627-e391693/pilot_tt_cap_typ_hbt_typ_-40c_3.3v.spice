* tb_vco_core_tran -- oscillator-core startup / f_osc / supply-current bench
* record 20260926-010627-e391693   corner pilot_tt_cap_typ_hbt_typ_-40c_3.3v
*
* GENERATED FILE. The committed source is
* sim/oscillator-core/testbench/tb_vco_core_tran.spice.tmpl; every @@TOKEN@@
* below is substituted by sim/oscillator-core/osc_bench.sh. A copy of the
* substituted deck is frozen per simulated point under
* sim/oscillator-core/netlist-snapshots/<record-id>/, per sim/README.md rule 3.
*
* WHAT THIS MEASURES, AND HOW
* ---------------------------
* ngspice ships no PSS and no pnoise, so there is no harmonic-balance
* oscillator solve to ask for a frequency. This bench therefore measures
* f_osc the only way this simulator can: a TRANSIENT from a small
* differential initial condition, followed by crossing-counted period
* extraction over a window that excludes the startup ramp. The extractor is
* sim/lib.sh's osc_metrics(); its accuracy is not asserted here, it is
* MEASURED against synthetic waveforms of known frequency by
* sim/oscillator-core/run_method_check.sh.
*
* Transient settings, and why each is what it is. These restate
* design/vco.spice's reasoning as this bench's own measured settings rather
* than citing a comment in another directory:
*
*   timestep ceiling 2p  -- 1/2p sampled per second gives ~100
*       samples per period at the 5 GHz row-1 target, which is where
*       run_method_check.sh measures the extractor's own error to be
*       < 1e-6 relative on frequency and < 0.02 % on peak-to-peak. The
*       ceiling is an accuracy floor for the CIRCUIT solution too (the OSDI
*       varactor bank's charge and the HBT's exponential are both stiff).
*       It is NOT a cost lever: the same 2 ns transient measured 169 s at a
*       2 ps ceiling and 183 s at 5 ps, so coarsening buys no CPU time and
*       only discretization error. run_pilot_grid.sh runs the nominal point
*       at both ceilings and records the resulting delta on f_osc rather than
*       leaving the question open.
*   stop time 5n       -- see osc_bench.sh's OSC_TSTOP header. The
*       window is set from the MEASURED settling time (0.883 ns at the
*       nominal corner), not from the "completes inside the first
*       nanosecond" assertion in design/vco.spice's comments.
*   discarded startup window 0 .. 2.5e-9 -- everything before
*       2.5e-9 is thrown away, so the recorded frequency and
*       amplitude are of the settled oscillation. That is 2.8x the measured
*       nominal settling time. The startup transient itself is not discarded
*       as a measurement: osc_settle() reports when the envelope reached
*       0.9 of its final amplitude, from this same trace, and a
*       corner whose envelope never got there records t_settle_s = nan.
*   measurement window 2.5e-9 .. 5n -- ~13 settled periods at
*       the measured 5.4 GHz. The resulting frequency quantization floor is
*       ~0.08 % interpolated (~7.4 % without interpolation) and BOTH are
*       stated with every number the run records (see osc_metrics()' header
*       and README.md).
*
* THE STARTUP INITIAL CONDITION IS NOT DECORATION
* A perfectly symmetric cross-coupled pair sits on an unstable DC
* equilibrium. The .ic below is the 10 mV differential
* perturbation that lets the startup transient leave it -- an initial
* condition, not a drive: it is never refreshed. design/vco.spice carries the
* same mechanism; this bench restates it explicitly so the deck is readable
* on its own and so the perturbation amplitude is a bench parameter the
* margin proxy can compare an envelope against.
*
* THE DIFFERENTIAL-MODE CHECK IS NOT OPTIONAL
* VDIFF / VCM / VTL below are high-impedance observation nodes (1 Gohm to
* ground, no path to the tank -- they cannot load it). A genuinely
* differential tank puts the whole fundamental into VDIFF and leaves the
* common mode and the tail node with only the 2f component the two
* half-circuits pump in phase. Two independently resonating branches would
* instead show a FUNDAMENTAL in VCM. The run records Vpp(VCM)/Vpp(VDIFF) and
* both f(VCM)/f_osc and f(TAIL)/f_osc for exactly that test; without it every
* frequency and tuning number above would be measuring the wrong circuit.

* ----------------------------------------------------------------- models
* Three separate PDK corner libraries, because SG13G2 ships one per device
* family and this circuit contains all three. The non-PDK inductor model is
* named by path here and by path + content sha256 in the record: the PDK
* ships NO spiral-inductor model (sim/pdk.json known_model_gaps), so every
* frequency this bench produces inherits that model's stated error bars.
.lib /home/ubuntu/share/pdk/ihp-sg13g2/libs.tech/ngspice/models/cornerHBT.lib hbt_typ
.lib /home/ubuntu/share/pdk/ihp-sg13g2/libs.tech/ngspice/models/cornerMOShv.lib mos_tt
.lib /home/ubuntu/share/pdk/ihp-sg13g2/libs.tech/ngspice/models/cornerCAP.lib cap_typ
.include /home/ubuntu/GitHub/sg13g2-vco/.loom/worktrees/issue-47/sim/inductor-model/sg13g2_inductor_em.spice
.temp -40

* --------------------------------------------- device under test (verbatim)
* The lines between the markers are copied UNCHANGED out of
* design/vco.spice, which is itself derived from design/vco.sch by
* design/netlist.sh. osc_bench.sh runs `design/netlist.sh --check` before it
* generates anything, so this deck can never grade a netlist that has drifted
* from the schematic. Two lines of design/vco.spice are deliberately NOT
* copied: its `.save i(vsup)` card (a .save RESTRICTS the saved set, which
* would make every node voltage below unavailable), and its own elaboration
* `.control` block (this bench supplies its own analysis).
* ---- begin design/vco.spice device section ----
XL1 VDD OUTP 0 inductor w=8.22e-6 s=3.74e-6 d=141.975e-6 nr_r=4 m=1
XL2 VDD OUTN 0 inductor w=8.22e-6 s=3.74e-6 d=141.975e-6 nr_r=4 m=1
XC1 OUTP OUTN cap_cmim w=3.65e-6 l=3.65e-6 m=1
XCVP1 VCTRL OUTP VCTRL OUTP sg13_hv_svaricap w=3.74e-6 l=0.3e-6 Nx=1
XCVP2 VCTRL OUTP VCTRL OUTP sg13_hv_svaricap w=3.74e-6 l=0.3e-6 Nx=1
XCVP3 VCTRL OUTP VCTRL OUTP sg13_hv_svaricap w=3.74e-6 l=0.3e-6 Nx=1
XCVP4 VCTRL OUTP VCTRL OUTP sg13_hv_svaricap w=3.74e-6 l=0.3e-6 Nx=1
XCVP5 VCTRL OUTP VCTRL OUTP sg13_hv_svaricap w=3.74e-6 l=0.3e-6 Nx=1
XCVP6 VCTRL OUTP VCTRL OUTP sg13_hv_svaricap w=3.74e-6 l=0.3e-6 Nx=1
XCVP7 VCTRL OUTP VCTRL OUTP sg13_hv_svaricap w=3.74e-6 l=0.3e-6 Nx=1
XCVP8 VCTRL OUTP VCTRL OUTP sg13_hv_svaricap w=3.74e-6 l=0.3e-6 Nx=1
XCVP9 VCTRL OUTP VCTRL OUTP sg13_hv_svaricap w=3.74e-6 l=0.3e-6 Nx=1
XCVP10 VCTRL OUTP VCTRL OUTP sg13_hv_svaricap w=3.74e-6 l=0.3e-6 Nx=1
XCVP11 VCTRL OUTP VCTRL OUTP sg13_hv_svaricap w=3.74e-6 l=0.3e-6 Nx=1
XCVP12 VCTRL OUTP VCTRL OUTP sg13_hv_svaricap w=3.74e-6 l=0.3e-6 Nx=1
XCVP13 VCTRL OUTP VCTRL OUTP sg13_hv_svaricap w=3.74e-6 l=0.3e-6 Nx=1
XCVP14 VCTRL OUTP VCTRL OUTP sg13_hv_svaricap w=3.74e-6 l=0.3e-6 Nx=1
XCVP15 VCTRL OUTP VCTRL OUTP sg13_hv_svaricap w=3.74e-6 l=0.3e-6 Nx=1
XCVP16 VCTRL OUTP VCTRL OUTP sg13_hv_svaricap w=3.74e-6 l=0.3e-6 Nx=1
XCVN1 VCTRL OUTN VCTRL OUTN sg13_hv_svaricap w=3.74e-6 l=0.3e-6 Nx=1
XCVN2 VCTRL OUTN VCTRL OUTN sg13_hv_svaricap w=3.74e-6 l=0.3e-6 Nx=1
XCVN3 VCTRL OUTN VCTRL OUTN sg13_hv_svaricap w=3.74e-6 l=0.3e-6 Nx=1
XCVN4 VCTRL OUTN VCTRL OUTN sg13_hv_svaricap w=3.74e-6 l=0.3e-6 Nx=1
XCVN5 VCTRL OUTN VCTRL OUTN sg13_hv_svaricap w=3.74e-6 l=0.3e-6 Nx=1
XCVN6 VCTRL OUTN VCTRL OUTN sg13_hv_svaricap w=3.74e-6 l=0.3e-6 Nx=1
XCVN7 VCTRL OUTN VCTRL OUTN sg13_hv_svaricap w=3.74e-6 l=0.3e-6 Nx=1
XCVN8 VCTRL OUTN VCTRL OUTN sg13_hv_svaricap w=3.74e-6 l=0.3e-6 Nx=1
XCVN9 VCTRL OUTN VCTRL OUTN sg13_hv_svaricap w=3.74e-6 l=0.3e-6 Nx=1
XCVN10 VCTRL OUTN VCTRL OUTN sg13_hv_svaricap w=3.74e-6 l=0.3e-6 Nx=1
XCVN11 VCTRL OUTN VCTRL OUTN sg13_hv_svaricap w=3.74e-6 l=0.3e-6 Nx=1
XCVN12 VCTRL OUTN VCTRL OUTN sg13_hv_svaricap w=3.74e-6 l=0.3e-6 Nx=1
XCVN13 VCTRL OUTN VCTRL OUTN sg13_hv_svaricap w=3.74e-6 l=0.3e-6 Nx=1
XCVN14 VCTRL OUTN VCTRL OUTN sg13_hv_svaricap w=3.74e-6 l=0.3e-6 Nx=1
XCVN15 VCTRL OUTN VCTRL OUTN sg13_hv_svaricap w=3.74e-6 l=0.3e-6 Nx=1
XCVN16 VCTRL OUTN VCTRL OUTN sg13_hv_svaricap w=3.74e-6 l=0.3e-6 Nx=1
XQ1 OUTP OUTN TAIL 0 npn13G2v Nx=1 El=1.0
XQ2 OUTN OUTP TAIL 0 npn13G2v Nx=1 El=1.0
XQ3 TAIL NBIAS TE 0 npn13G2v Nx=1 El=2.0
RTE TE 0 2k m=1
RREF VDD NBIAS 20.5k m=1
XQ4 NBIAS NBIAS RE 0 npn13G2v Nx=1 El=1.0
RRE RE 0 4k m=1
VSUP VDD 0 dc 3.3
VCT VCTRL 0 dc 1.65
* ---- end design/vco.spice device section ----

* ------------------------------------------------------- observation nodes
Bvdiff VDIFF 0 V = V(OUTP) - V(OUTN)
Bvcm   VCM   0 V = (V(OUTP) + V(OUTN))/2 - 3.3
Bvtail VTL   0 V = V(TAIL)
Rvdiff VDIFF 0 1G
Rvcm   VCM   0 1G
Rvtail VTL   0 1G

.ic v(OUTP)=3.305 v(OUTN)=3.295

.control
* pre_osdi must come before the first analysis command: ngspice defers OSDI
* instantiation to analysis setup, so a `pre_osdi` issued later leaves the 32
* sg13_hv_svaricap instances unresolved. sim/tools/build-osdi.sh builds this
* binary; osc_bench.sh calls it, so a cold checkout needs no manual step.
pre_osdi /home/ubuntu/share/pdk/ihp-sg13g2/libs.tech/ngspice/osdi/mosvar.osdi
* The netlist's own `.save i(vsup)` is stripped (see above). This `save` names
* the ten vectors the extractors and the operating-point print actually read.
* It is NOT `save all`: `save all` additionally stores every internal node of
* the 32 varactor subcircuits, the two inductor ladders and the four HBTs at
* every accepted timepoint, which measured 169 s against 153 s for this same
* 2 ns transient (~10 % of the run) while producing a bit-identical extracted
* f_osc and Vpp. Naming the set is the cheaper and the more explicit of the
* two. It must stay in sync with the wrdata/print lines below -- a vector that
* is read but not saved comes back empty, and osc_simulate_point records that
* point as a FAIL rather than silently reporting a zero.
save v(VDIFF) v(VCM) v(VTL) i(VSUP) v(NBIAS) v(TE) v(RE) v(TAIL) v(OUTP) v(OUTN)
alter VCT dc = 3.3
op
* The DC operating point, printed so the record can report the SMALL-SIGNAL
* supply current separately from the large-signal one. Row 8 is the
* large-signal number -- the pair's average current shifts once it is
* switching -- but reporting only one of the two would hide which is which.
echo op_point_follows
print v(NBIAS) v(TE) v(RE) v(TAIL) v(OUTP) v(OUTN) i(VSUP)
tran 1p 5n 0 2p
let vdiff_w = v(VDIFF)
wrdata tr_pilot_tt_cap_typ_hbt_typ_-40c_3.3v_vdiff vdiff_w
let vcm_w = v(VCM)
wrdata tr_pilot_tt_cap_typ_hbt_typ_-40c_3.3v_vcm vcm_w
let vtail_w = v(VTL)
wrdata tr_pilot_tt_cap_typ_hbt_typ_-40c_3.3v_vtail vtail_w
* Sign flipped so the recorded number is current OUT of the rail.
let isup_w = -i(VSUP)
wrdata tr_pilot_tt_cap_typ_hbt_typ_-40c_3.3v_isup isup_w
.endc
.end
