.include /home/ubuntu/GitHub/sg13g2-vco/.loom/worktrees/issue-309/sim/oscillator-core/klt-sim/hot-startup-leakage/../hot-startup-trace/ind_orig.spice
.include /home/ubuntu/GitHub/sg13g2-vco/.loom/worktrees/issue-309/sim/oscillator-core/klt-sim/hot-startup-leakage/../hot-startup-trace/svar-fd.spice
XL1 VDD OUTP 0 inductor w=8.22e-6 s=3.74e-6 d=141.975e-6 nr_r=4 m=1
XL2 VDD OUTN 0 inductor w=8.22e-6 s=3.74e-6 d=141.975e-6 nr_r=4 m=1
XC1 OUTP OUTN cap_cmim w=3.65e-6 l=3.65e-6 m=1
XCVP1 VCTRL OUTP VCTRL 0 svar_loc w=3.74e-6 l=0.3e-6 Nx=1
XCVP2 VCTRL OUTP VCTRL 0 svar_loc w=3.74e-6 l=0.3e-6 Nx=1
XCVP3 VCTRL OUTP VCTRL 0 svar_loc w=3.74e-6 l=0.3e-6 Nx=1
XCVP4 VCTRL OUTP VCTRL 0 svar_loc w=3.74e-6 l=0.3e-6 Nx=1
XCVP5 VCTRL OUTP VCTRL 0 svar_loc w=3.74e-6 l=0.3e-6 Nx=1
XCVP6 VCTRL OUTP VCTRL 0 svar_loc w=3.74e-6 l=0.3e-6 Nx=1
XCVP7 VCTRL OUTP VCTRL 0 svar_loc w=3.74e-6 l=0.3e-6 Nx=1
XCVP8 VCTRL OUTP VCTRL 0 svar_loc w=3.74e-6 l=0.3e-6 Nx=1
XCVP9 VCTRL OUTP VCTRL 0 svar_loc w=3.74e-6 l=0.3e-6 Nx=1
XCVP10 VCTRL OUTP VCTRL 0 svar_loc w=3.74e-6 l=0.3e-6 Nx=1
XCVP11 VCTRL OUTP VCTRL 0 svar_loc w=3.74e-6 l=0.3e-6 Nx=1
XCVP12 VCTRL OUTP VCTRL 0 svar_loc w=3.74e-6 l=0.3e-6 Nx=1
XCVP13 VCTRL OUTP VCTRL 0 svar_loc w=3.74e-6 l=0.3e-6 Nx=1
XCVP14 VCTRL OUTP VCTRL 0 svar_loc w=3.74e-6 l=0.3e-6 Nx=1
XCVP15 VCTRL OUTP VCTRL 0 svar_loc w=3.74e-6 l=0.3e-6 Nx=1
XCVP16 VCTRL OUTP VCTRL 0 svar_loc w=3.74e-6 l=0.3e-6 Nx=1
XCVN1 VCTRL OUTN VCTRL 0 svar_loc w=3.74e-6 l=0.3e-6 Nx=1
XCVN2 VCTRL OUTN VCTRL 0 svar_loc w=3.74e-6 l=0.3e-6 Nx=1
XCVN3 VCTRL OUTN VCTRL 0 svar_loc w=3.74e-6 l=0.3e-6 Nx=1
XCVN4 VCTRL OUTN VCTRL 0 svar_loc w=3.74e-6 l=0.3e-6 Nx=1
XCVN5 VCTRL OUTN VCTRL 0 svar_loc w=3.74e-6 l=0.3e-6 Nx=1
XCVN6 VCTRL OUTN VCTRL 0 svar_loc w=3.74e-6 l=0.3e-6 Nx=1
XCVN7 VCTRL OUTN VCTRL 0 svar_loc w=3.74e-6 l=0.3e-6 Nx=1
XCVN8 VCTRL OUTN VCTRL 0 svar_loc w=3.74e-6 l=0.3e-6 Nx=1
XCVN9 VCTRL OUTN VCTRL 0 svar_loc w=3.74e-6 l=0.3e-6 Nx=1
XCVN10 VCTRL OUTN VCTRL 0 svar_loc w=3.74e-6 l=0.3e-6 Nx=1
XCVN11 VCTRL OUTN VCTRL 0 svar_loc w=3.74e-6 l=0.3e-6 Nx=1
XCVN12 VCTRL OUTN VCTRL 0 svar_loc w=3.74e-6 l=0.3e-6 Nx=1
XCVN13 VCTRL OUTN VCTRL 0 svar_loc w=3.74e-6 l=0.3e-6 Nx=1
XCVN14 VCTRL OUTN VCTRL 0 svar_loc w=3.74e-6 l=0.3e-6 Nx=1
XCVN15 VCTRL OUTN VCTRL 0 svar_loc w=3.74e-6 l=0.3e-6 Nx=1
XCVN16 VCTRL OUTN VCTRL 0 svar_loc w=3.74e-6 l=0.3e-6 Nx=1
XQ1 OUTP OUTN TAIL 0 npn13G2v Nx=1 El=1.0
XQ2 OUTN OUTP TAIL 0 npn13G2v Nx=1 El=1.0
XQ3 TAIL NBIAS TE 0 npn13G2v Nx=1 El=2.0
RTE TE 0 2k m=1
RREF VDD NBIAS 20.5k m=1
XQ4 NBIAS NBIAS RE 0 npn13G2v Nx=1 El=1.0
RRE RE 0 4k m=1
VSUP VDD 0 pwl(0 0 500p 3.3)
VCT VCTRL 0 dc 1.65
Bvdiff VDIFF 0 V = V(OUTP) - V(OUTN)
.ic v(OUTP)=0.005 v(OUTN)=0
.options tnom=125
.ic v(xcvP1.w0)=3.3 v(xcvP1.w1)=0 v(xcvP2.w0)=3.3 v(xcvP2.w1)=0 v(xcvP3.w0)=3.3 v(xcvP3.w1)=0 v(xcvP4.w0)=3.3 v(xcvP4.w1)=0 v(xcvP5.w0)=3.3 v(xcvP5.w1)=0 v(xcvP6.w0)=3.3 v(xcvP6.w1)=0 v(xcvP7.w0)=3.3 v(xcvP7.w1)=0 v(xcvP8.w0)=3.3 v(xcvP8.w1)=0 v(xcvP9.w0)=3.3 v(xcvP9.w1)=0 v(xcvP10.w0)=3.3 v(xcvP10.w1)=0 v(xcvP11.w0)=3.3 v(xcvP11.w1)=0 v(xcvP12.w0)=3.3 v(xcvP12.w1)=0 v(xcvP13.w0)=3.3 v(xcvP13.w1)=0 v(xcvP14.w0)=3.3 v(xcvP14.w1)=0 v(xcvP15.w0)=3.3 v(xcvP15.w1)=0 v(xcvP16.w0)=3.3 v(xcvP16.w1)=0 v(xcvN1.w0)=3.3 v(xcvN1.w1)=0 v(xcvN2.w0)=3.3 v(xcvN2.w1)=0 v(xcvN3.w0)=3.3 v(xcvN3.w1)=0 v(xcvN4.w0)=3.3 v(xcvN4.w1)=0 v(xcvN5.w0)=3.3 v(xcvN5.w1)=0 v(xcvN6.w0)=3.3 v(xcvN6.w1)=0 v(xcvN7.w0)=3.3 v(xcvN7.w1)=0 v(xcvN8.w0)=3.3 v(xcvN8.w1)=0 v(xcvN9.w0)=3.3 v(xcvN9.w1)=0 v(xcvN10.w0)=3.3 v(xcvN10.w1)=0 v(xcvN11.w0)=3.3 v(xcvN11.w1)=0 v(xcvN12.w0)=3.3 v(xcvN12.w1)=0 v(xcvN13.w0)=3.3 v(xcvN13.w1)=0 v(xcvN14.w0)=3.3 v(xcvN14.w1)=0 v(xcvN15.w0)=3.3 v(xcvN15.w1)=0 v(xcvN16.w0)=3.3 v(xcvN16.w1)=0
