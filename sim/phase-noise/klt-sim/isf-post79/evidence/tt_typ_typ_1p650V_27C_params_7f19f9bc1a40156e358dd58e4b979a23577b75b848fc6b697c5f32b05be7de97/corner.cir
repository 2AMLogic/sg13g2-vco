* klt sim -- generated corner deck, do not edit
.lib /opt/pdk/ihp-sg13g2/libs.tech/ngspice/models/cornerHBT.lib hbt_typ
.lib /opt/pdk/ihp-sg13g2/libs.tech/ngspice/models/cornerMOShv.lib mos_tt
.lib /opt/pdk/ihp-sg13g2/libs.tech/ngspice/models/cornerCAP.lib cap_typ
.include /var/tmp/eda-job-klt-sim-c37390425454/inputs/netlist.cir
.temp 27
.meas tran vdiff_max MAX v(vdiff) FROM=2.5n TO=1.088623e-08
.control
pre_osdi /opt/pdk/ihp-sg13g2/libs.tech/ngspice/osdi/mosvar.osdi
alterparam dqd=8e-15
alterparam dqt=0
reset
save all
alter vct=1.65
set filetype=ascii
tran 1p 1.088622825828e-08 0 2p
write /var/tmp/eda-job-klt-sim-c37390425454/outputs/artifacts/tt_typ_typ_1p650V_27C_params_7f19f9bc1a40156e358dd58e4b979a23577b75b848fc6b697c5f32b05be7de97/waveform.raw
quit
.endc
.end
