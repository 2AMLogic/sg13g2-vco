.include sg13g2_inductor_em.spice
XL1 VDD OUTP 0 inductor w=8.22e-6 s=3.74e-6 d=141.975e-6 nr_r=4 m=1
XL2 VDD OUTN 0 inductor w=8.22e-6 s=3.74e-6 d=141.975e-6 nr_r=4 m=1
XC1 OUTP OUTN cap_cmim w=3.65e-6 l=3.65e-6 m=1
XCVP1 VCTRL OUTP VCTRL 0 sg13_hv_svaricap w=3.74e-6 l=0.3e-6 Nx=1
XCVP2 VCTRL OUTP VCTRL 0 sg13_hv_svaricap w=3.74e-6 l=0.3e-6 Nx=1
XCVP3 VCTRL OUTP VCTRL 0 sg13_hv_svaricap w=3.74e-6 l=0.3e-6 Nx=1
XCVP4 VCTRL OUTP VCTRL 0 sg13_hv_svaricap w=3.74e-6 l=0.3e-6 Nx=1
XCVP5 VCTRL OUTP VCTRL 0 sg13_hv_svaricap w=3.74e-6 l=0.3e-6 Nx=1
XCVP6 VCTRL OUTP VCTRL 0 sg13_hv_svaricap w=3.74e-6 l=0.3e-6 Nx=1
XCVP7 VCTRL OUTP VCTRL 0 sg13_hv_svaricap w=3.74e-6 l=0.3e-6 Nx=1
XCVP8 VCTRL OUTP VCTRL 0 sg13_hv_svaricap w=3.74e-6 l=0.3e-6 Nx=1
XCVP9 VCTRL OUTP VCTRL 0 sg13_hv_svaricap w=3.74e-6 l=0.3e-6 Nx=1
XCVP10 VCTRL OUTP VCTRL 0 sg13_hv_svaricap w=3.74e-6 l=0.3e-6 Nx=1
XCVP11 VCTRL OUTP VCTRL 0 sg13_hv_svaricap w=3.74e-6 l=0.3e-6 Nx=1
XCVP12 VCTRL OUTP VCTRL 0 sg13_hv_svaricap w=3.74e-6 l=0.3e-6 Nx=1
XCVP13 VCTRL OUTP VCTRL 0 sg13_hv_svaricap w=3.74e-6 l=0.3e-6 Nx=1
XCVP14 VCTRL OUTP VCTRL 0 sg13_hv_svaricap w=3.74e-6 l=0.3e-6 Nx=1
XCVP15 VCTRL OUTP VCTRL 0 sg13_hv_svaricap w=3.74e-6 l=0.3e-6 Nx=1
XCVP16 VCTRL OUTP VCTRL 0 sg13_hv_svaricap w=3.74e-6 l=0.3e-6 Nx=1
XCVN1 VCTRL OUTN VCTRL 0 sg13_hv_svaricap w=3.74e-6 l=0.3e-6 Nx=1
XCVN2 VCTRL OUTN VCTRL 0 sg13_hv_svaricap w=3.74e-6 l=0.3e-6 Nx=1
XCVN3 VCTRL OUTN VCTRL 0 sg13_hv_svaricap w=3.74e-6 l=0.3e-6 Nx=1
XCVN4 VCTRL OUTN VCTRL 0 sg13_hv_svaricap w=3.74e-6 l=0.3e-6 Nx=1
XCVN5 VCTRL OUTN VCTRL 0 sg13_hv_svaricap w=3.74e-6 l=0.3e-6 Nx=1
XCVN6 VCTRL OUTN VCTRL 0 sg13_hv_svaricap w=3.74e-6 l=0.3e-6 Nx=1
XCVN7 VCTRL OUTN VCTRL 0 sg13_hv_svaricap w=3.74e-6 l=0.3e-6 Nx=1
XCVN8 VCTRL OUTN VCTRL 0 sg13_hv_svaricap w=3.74e-6 l=0.3e-6 Nx=1
XCVN9 VCTRL OUTN VCTRL 0 sg13_hv_svaricap w=3.74e-6 l=0.3e-6 Nx=1
XCVN10 VCTRL OUTN VCTRL 0 sg13_hv_svaricap w=3.74e-6 l=0.3e-6 Nx=1
XCVN11 VCTRL OUTN VCTRL 0 sg13_hv_svaricap w=3.74e-6 l=0.3e-6 Nx=1
XCVN12 VCTRL OUTN VCTRL 0 sg13_hv_svaricap w=3.74e-6 l=0.3e-6 Nx=1
XCVN13 VCTRL OUTN VCTRL 0 sg13_hv_svaricap w=3.74e-6 l=0.3e-6 Nx=1
XCVN14 VCTRL OUTN VCTRL 0 sg13_hv_svaricap w=3.74e-6 l=0.3e-6 Nx=1
XCVN15 VCTRL OUTN VCTRL 0 sg13_hv_svaricap w=3.74e-6 l=0.3e-6 Nx=1
XCVN16 VCTRL OUTN VCTRL 0 sg13_hv_svaricap w=3.74e-6 l=0.3e-6 Nx=1
XQ1 OUTP OUTN TAIL 0 npn13G2v Nx=1 El=1.0
XQ2 OUTN OUTP TAIL 0 npn13G2v Nx=1 El=1.0
XQ3 TAIL NBIAS TE 0 npn13G2v Nx=1 El=2.0
RTE TE 0 2k m=1
RREF VDD NBIAS 20.5k m=1
XQ4 NBIAS NBIAS RE 0 npn13G2v Nx=1 El=1.0
RRE RE 0 4k m=1
VSUP VDD 0 dc 3.3
VCT VCTRL 0 dc 1.65
Bvdiff VDIFF 0 V = V(OUTP) - V(OUTN)
Bvcm VCM 0 V = (V(OUTP) + V(OUTN)) / 2
.ic v(OUTP)=3.305 v(OUTN)=3.295

* ISF impulse trains (sim/phase-noise/pn_bench.sh schedule); amplitude = dq/hw from .param rows
.param dqd=0 dqt=0
IISFD OUTN OUTP PWL(0 0 3.498000000000e-09 0 3.500000000000e-09 {dqd/2.000000e-12} 3.502000000000e-09 0 5.666366252787e-09 0 5.668366252787e-09 {dqd/2.000000e-12} 5.670366252787e-09 0 7.834732505573e-09 0 7.836732505573e-09 {dqd/2.000000e-12} 7.838732505573e-09 0 1.000309875836e-08 0 1.000509875836e-08 {dqd/2.000000e-12} 1.000709875836e-08 0 1.217146501115e-08 0 1.217346501115e-08 {dqd/2.000000e-12} 1.217546501115e-08 0 1.433983126393e-08 0 1.434183126393e-08 {dqd/2.000000e-12} 1.434383126393e-08 0 1.650819751672e-08 0 1.651019751672e-08 {dqd/2.000000e-12} 1.651219751672e-08 0 1.867656376951e-08 0 1.867856376951e-08 {dqd/2.000000e-12} 1.868056376951e-08 0 2.084493002229e-08 0 2.084693002229e-08 {dqd/2.000000e-12} 2.084893002229e-08 0 2.301329627508e-08 0 2.301529627508e-08 {dqd/2.000000e-12} 2.301729627508e-08 0)
IISFT 0 TAIL PWL(0 0 3.498000000000e-09 0 3.500000000000e-09 {dqt/2.000000e-12} 3.502000000000e-09 0 5.666366252787e-09 0 5.668366252787e-09 {dqt/2.000000e-12} 5.670366252787e-09 0 7.834732505573e-09 0 7.836732505573e-09 {dqt/2.000000e-12} 7.838732505573e-09 0 1.000309875836e-08 0 1.000509875836e-08 {dqt/2.000000e-12} 1.000709875836e-08 0 1.217146501115e-08 0 1.217346501115e-08 {dqt/2.000000e-12} 1.217546501115e-08 0 1.433983126393e-08 0 1.434183126393e-08 {dqt/2.000000e-12} 1.434383126393e-08 0 1.650819751672e-08 0 1.651019751672e-08 {dqt/2.000000e-12} 1.651219751672e-08 0 1.867656376951e-08 0 1.867856376951e-08 {dqt/2.000000e-12} 1.868056376951e-08 0 2.084493002229e-08 0 2.084693002229e-08 {dqt/2.000000e-12} 2.084893002229e-08 0 2.301329627508e-08 0 2.301529627508e-08 {dqt/2.000000e-12} 2.301729627508e-08 0)
