* klt sim -- generated corner deck, do not edit
.lib /opt/pdk/ihp-sg13g2/libs.tech/ngspice/models/cornerHBT.lib hbt_typ
.lib /opt/pdk/ihp-sg13g2/libs.tech/ngspice/models/cornerMOShv.lib mos_tt
.lib /opt/pdk/ihp-sg13g2/libs.tech/ngspice/models/cornerCAP.lib cap_typ
.include /var/tmp/eda-job-klt-sim-1dfa416c0f4a/inputs/netlist.cir
.temp 27
.meas tran vdiff_max MAX v(vdiff) FROM=2.5n TO=2.518366e-08
.control
pre_osdi /opt/pdk/ihp-sg13g2/libs.tech/ngspice/osdi/mosvar.osdi
alterparam dqd=4e-15
alterparam dqt=0
reset
save all
alter vct=1.65
set filetype=ascii
tran 1p 2.518366252787e-08 0 2p
write /var/tmp/eda-job-klt-sim-1dfa416c0f4a/outputs/artifacts/tt_typ_typ_1p650V_27C_params_e8eb26aa65eba631efdb094b3c11c203a16ddf7dd8f17a7d50e58f3386b73f2d/waveform.raw
quit
.endc
.end
