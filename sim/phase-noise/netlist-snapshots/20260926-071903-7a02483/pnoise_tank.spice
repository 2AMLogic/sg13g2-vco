* tb_vco_port_noise -- equivalent noise current at an injection port of design/vco.sch
* record 20260926-071903-7a02483   corner pnoise_tank   port tank
*
* GENERATED FILE. Committed source:
* sim/phase-noise/testbench/tb_vco_port_noise.spice.tmpl.
*
* WHAT THIS PRODUCES
* ------------------
* S_i, the ONE-SIDED equivalent (Norton) noise current PSD at one injection
* port of the oscillator, in A^2/Hz -- the second of the phase-noise kernel's
* two measured inputs (the first is the ISF, from
* tb_vco_isf_impulse.spice.tmpl).
*
* It is obtained from ngspice's small-signal `noise` analysis with a unit AC
* current probe ACROSS THE PORT and the port voltage as the output. Then
* gain = Z_port, and ngspice's input-referred `inoise_spectrum` is
* onoise/|Z_port| = the Norton-equivalent noise current density at that port
* in A/sqrt(Hz). Squaring it gives S_i. The identity, and that this deck asks
* ngspice for it correctly, is checked against a closed form in
* run_method_check.sh (tb_portnoise_known_answer.spice.tmpl).
*
* THE LIMIT THIS DECK CARRIES, STATED HERE AND IN EVERY RECORD
* ngspice's `noise` is a small-signal analysis about the DC OPERATING POINT.
* An oscillator's DC operating point is its UNSTABLE EQUILIBRIUM -- the
* symmetric state the cross-coupled pair sits in before it starts, with each
* device carrying half the tail current continuously. The running oscillator's
* noise sources are CYCLOSTATIONARY: they are modulated over the cycle as the
* pair switches. This deck therefore measures the noise of the devices at a
* bias they hold only on average, and treats it as stationary and white.
*
* That is a real approximation with a known sign for a switching pair (the
* equilibrium bias overstates the time each device spends in its high-noise
* state for a hard-switching oscillator, and understates it for a
* nearly-linear one), and this experiment does NOT correct it -- it states it,
* per CLAUDE.md. It is the single largest stated limit on the reported number.
* Capturing it properly needs the cyclostationary noise-modulation function of
* the full Hajimiri-Lee treatment, which in turn needs per-device noise
* waveforms over the cycle that ngspice cannot produce.
*
* A second, smaller consequence: because Z_port at an unstable equilibrium has
* a NEGATIVE real part near resonance, the raw output noise is not physically
* meaningful there. The input-referred RATIO is, and is what this deck reads --
* both numerator and denominator carry the same Z_port. The run script
* evaluates it over a band and records the whole band, not one point, so a
* reader can see whether the number was taken somewhere the referral was
* well conditioned.

.lib /home/ubuntu/share/pdk/ihp-sg13g2/libs.tech/ngspice/models/cornerHBT.lib hbt_typ
.lib /home/ubuntu/share/pdk/ihp-sg13g2/libs.tech/ngspice/models/cornerMOShv.lib mos_tt
.lib /home/ubuntu/share/pdk/ihp-sg13g2/libs.tech/ngspice/models/cornerCAP.lib cap_typ
.include /home/ubuntu/GitHub/sg13g2-vco/.loom/worktrees/issue-49/sim/inductor-model/sg13g2_inductor_em.spice
.temp 27

* ---- begin design/vco.spice device section ----
XL1 VDD OUTP 0 inductor w=8.22e-6 s=3.74e-6 d=141.975e-6 nr_r=4 m=1
XL2 VDD OUTN 0 inductor w=8.22e-6 s=3.74e-6 d=141.975e-6 nr_r=4 m=1
XC1 OUTP OUTN cap_cmim w=3.65e-6 l=3.65e-6 m=1
XCVP1 VCTRL OUTP VCTRL OUTP sg13_hv_svaricap w=3.74e-6 l=0.3e-6 Nx=1
XCVP2 VCTRL OUTP VCTRL OUTP sg13_hv_svaricap w=3.74e-6 l=0.3e-6 Nx=1
XCVP3 VCTRL OUTP VCTRL OUTP sg13_hv_svaricap w=3.74e-6 l=0.3e-6 Nx=1
XCVP4 VCTRL OUTP VCTRL OUTP sg13_hv_svaricap w=3.74e-6 l=0.3e-6 Nx=1
XCVP5 VCTRL OUTP VCTRL OUTP sg13_hv_svaricap w=3.74e-6 l=0.3e-6 Nx=1
XCVP6 VCTRL OUTP VCTRL OUTP sg13_hv_svaricap w=3.74e-6 l=0.3e-6 Nx=1
XCVP7 VCTRL OUTP VCTRL OUTP sg13_hv_svaricap w=3.74e-6 l=0.3e-6 Nx=1
XCVP8 VCTRL OUTP VCTRL OUTP sg13_hv_svaricap w=3.74e-6 l=0.3e-6 Nx=1
XCVP9 VCTRL OUTP VCTRL OUTP sg13_hv_svaricap w=3.74e-6 l=0.3e-6 Nx=1
XCVP10 VCTRL OUTP VCTRL OUTP sg13_hv_svaricap w=3.74e-6 l=0.3e-6 Nx=1
XCVP11 VCTRL OUTP VCTRL OUTP sg13_hv_svaricap w=3.74e-6 l=0.3e-6 Nx=1
XCVP12 VCTRL OUTP VCTRL OUTP sg13_hv_svaricap w=3.74e-6 l=0.3e-6 Nx=1
XCVP13 VCTRL OUTP VCTRL OUTP sg13_hv_svaricap w=3.74e-6 l=0.3e-6 Nx=1
XCVP14 VCTRL OUTP VCTRL OUTP sg13_hv_svaricap w=3.74e-6 l=0.3e-6 Nx=1
XCVP15 VCTRL OUTP VCTRL OUTP sg13_hv_svaricap w=3.74e-6 l=0.3e-6 Nx=1
XCVP16 VCTRL OUTP VCTRL OUTP sg13_hv_svaricap w=3.74e-6 l=0.3e-6 Nx=1
XCVN1 VCTRL OUTN VCTRL OUTN sg13_hv_svaricap w=3.74e-6 l=0.3e-6 Nx=1
XCVN2 VCTRL OUTN VCTRL OUTN sg13_hv_svaricap w=3.74e-6 l=0.3e-6 Nx=1
XCVN3 VCTRL OUTN VCTRL OUTN sg13_hv_svaricap w=3.74e-6 l=0.3e-6 Nx=1
XCVN4 VCTRL OUTN VCTRL OUTN sg13_hv_svaricap w=3.74e-6 l=0.3e-6 Nx=1
XCVN5 VCTRL OUTN VCTRL OUTN sg13_hv_svaricap w=3.74e-6 l=0.3e-6 Nx=1
XCVN6 VCTRL OUTN VCTRL OUTN sg13_hv_svaricap w=3.74e-6 l=0.3e-6 Nx=1
XCVN7 VCTRL OUTN VCTRL OUTN sg13_hv_svaricap w=3.74e-6 l=0.3e-6 Nx=1
XCVN8 VCTRL OUTN VCTRL OUTN sg13_hv_svaricap w=3.74e-6 l=0.3e-6 Nx=1
XCVN9 VCTRL OUTN VCTRL OUTN sg13_hv_svaricap w=3.74e-6 l=0.3e-6 Nx=1
XCVN10 VCTRL OUTN VCTRL OUTN sg13_hv_svaricap w=3.74e-6 l=0.3e-6 Nx=1
XCVN11 VCTRL OUTN VCTRL OUTN sg13_hv_svaricap w=3.74e-6 l=0.3e-6 Nx=1
XCVN12 VCTRL OUTN VCTRL OUTN sg13_hv_svaricap w=3.74e-6 l=0.3e-6 Nx=1
XCVN13 VCTRL OUTN VCTRL OUTN sg13_hv_svaricap w=3.74e-6 l=0.3e-6 Nx=1
XCVN14 VCTRL OUTN VCTRL OUTN sg13_hv_svaricap w=3.74e-6 l=0.3e-6 Nx=1
XCVN15 VCTRL OUTN VCTRL OUTN sg13_hv_svaricap w=3.74e-6 l=0.3e-6 Nx=1
XCVN16 VCTRL OUTN VCTRL OUTN sg13_hv_svaricap w=3.74e-6 l=0.3e-6 Nx=1
XQ1 OUTP OUTN TAIL 0 npn13G2v Nx=1 El=1.0
XQ2 OUTN OUTP TAIL 0 npn13G2v Nx=1 El=1.0
XQ3 TAIL NBIAS TE 0 npn13G2v Nx=1 El=2.0
RTE TE 0 2k m=1
RREF VDD NBIAS 20.5k m=1
XQ4 NBIAS NBIAS RE 0 npn13G2v Nx=1 El=1.0
RRE RE 0 4k m=1
VSUP VDD 0 dc 3.3
VCT VCTRL 0 dc 1.65
* ---- end design/vco.spice device section ----

* The probe defines the port. It is `dc 0`, so it perturbs no bias; only the
* `noise` analysis reads its AC value. IPROBE OUTN OUTP dc 0 ac 1 and v(OUTP,OUTN) are
* substituted as a matched pair by pn_bench.sh, so the probe and the output
* can never name different ports.
IPROBE OUTN OUTP dc 0 ac 1

.control
pre_osdi /home/ubuntu/share/pdk/ihp-sg13g2/libs.tech/ngspice/osdi/mosvar.osdi
alter VCT dc = 1.65
op
echo op_point_follows
print v(NBIAS) v(TE) v(TAIL) v(OUTP) v(OUTN) i(VSUP)
noise v(OUTP,OUTN) IPROBE lin 7 3e9 9e9
setplot noise1
print inoise_spectrum
.endc
.end
